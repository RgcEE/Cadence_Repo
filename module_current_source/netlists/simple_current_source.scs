// Design: sense_amp_lib/simple_current_source
simulator lang=spectre
global 0
parameters R_l=1u R_w=1.35m Vm2=0.4 Rs=1.35M Vdd=3.3 Wl=500n Wl2=500n Wn=1u Wn2=1u
include "/home/gome0081/Cadence_Repo/cadence/models/ptm_180nm_ss.scs"

// sense_amp_lib/simple_current_source/schematic
M1 (net8 net8 0 0) NMOS w=Wn l=Wl
M2 (Vm2 net8 0 0) NMOS w=Wn2 l=Wl2
Rs1 (Vdc net8) resistor r=Rs l=R_l w=R_w
V1 (Vm2 0) vsource dc=Vm2 mag=1 type=dc
V0 (Vdc 0) vsource dc=Vdd mag=1 type=dc
simulatorOptions options temp=27
dcOp dc
dc dc param=temp start=-40 stop=140
save Vdc M2:d M1:d M2:g M1:g net8 Vm2
