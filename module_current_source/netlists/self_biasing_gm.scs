// Design: sense_amp_lib/self_biasing_current_source
simulator lang=spectre
global 0
parameters Vm2=1.5 Wn_M0=4u Wn_M1=2u Ln=800n Lp=800n Rs=2062 Vac=1 Vdd=3.3 Wp=4u
include "/home/gome0081/Cadence_Repo/cadence/models/ptm_180nm_ss.scs"

// sense_amp_lib/self_biasing_current_source/schematic
M1 (net6 net7 net13 0) NMOS w=Wn_M1 l=Ln
M0 (net7 net7 0 0) NMOS w=Wn_M0 l=Ln
M4 (net017 net6 Vin Vin) PMOS w=Wp l=Lp
M3 (net7 net6 Vin Vin) PMOS w=Wp l=Lp
M2 (net6 net6 Vin Vin) PMOS w=Wp l=Lp
Rs2 (net13 0) resistor r=Rs
VDD (Vin 0) vsource dc=Vdd mag=Vac type=dc
V1 (net017 0) vsource dc=Vm2 type=dc
nodeset net6=2.7 net7=0.6 net13=0.3
ic net6=2.7 net7=0.6 net13=0.3
simulatorOptions options temp=27
dcOp dc
dc dc param=temp start=-40 stop=140
save M4:d
